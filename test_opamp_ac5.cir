* ============================================================
* Testbench: AC Open-Loop Gain — Using .print ac
* ============================================================
.title AC Open-Loop — SKY130 Two-Stage Op-Amp

VDD vdd 0 1.8
VSS vss 0 0

.include "spice/sky130_models.spice"
.include "spice/opamp_subcircuit.spice"

XOPAMP vinp vinn vout vdd vss opamp_two_stage

* Input with AC excitation
VDC vinp 0 DC 0.9 AC 1

* Large feedback resistor to set DC bias without loading AC
RFB vout vinn 10meg

* Load
CL vout 0 5p

.ac dec 100 1 1G

.print ac vm(vout) vp(vout) vdb(vout)

.control
ac dec 100 1 1G
wrdata results/ac_openloop.txt v(vout)
quit
.endc

.end
