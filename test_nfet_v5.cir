.title SKY130 NMOS Test - X prefix (correct SKY130+ngspice approach)
.include "spice/sky130_models.spice"

VDD vdd 0 1.8
X1 drain gate 0 0 sky130_fd_pr__nfet_01v8 W=4.0u L=2.0u
VGS gate 0 DC 0.62
RD vdd drain 100k

.op
.control
op
print v(drain) v(gate)
print @x1.m0[id] @x1.m0[vgs] @x1.m0[vds] @x1.m0[vth] @x1.m0[gm]
quit
.endc
.end
